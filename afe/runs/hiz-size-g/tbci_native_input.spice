** sch_path: /foss/designs/afe/xschem/tbci_native_input.sch
.subckt tbci_native_input AVDD AVSS VCM IREF_SINK VINP VINN OUTP OUTN
*.PININFO IREF_SINK:B AVSS:B OUTN:O VINP:I OUTP:O VINN:I AVDD:B VCM:I
XMREF IREF_SINK IREF_SINK AVDD AVDD sky130_fd_pr__pfet_g5v0d10v5 L=3 W=80 nf=8 ad=11.6 as=14.5 pd=82.32 ps=102.9
+ nrd=0.0036249999999999998 nrs=0.0036249999999999998 sa=0 sb=0 sd=0 mult=1
XMCPY NBIAS IREF_SINK AVDD AVDD sky130_fd_pr__pfet_g5v0d10v5 L=3 W=80 nf=8 ad=11.6 as=14.5 pd=82.32 ps=102.9
+ nrd=0.0036249999999999998 nrs=0.0036249999999999998 sa=0 sb=0 sd=0 mult=1
XMNREF NBIAS NBIAS AVSS AVSS sky130_fd_pr__nfet_g5v0d10v5 L=3 W=80 nf=8 ad=11.6 as=14.5 pd=82.32 ps=102.9
+ nrd=0.0036249999999999998 nrs=0.0036249999999999998 sa=0 sb=0 sd=0 mult=1
XMNTAIL net2 NBIAS AVSS AVSS sky130_fd_pr__nfet_g5v0d10v5 L=3 W=320 nf=32 ad=46.4 as=49.3 pd=329.28 ps=349.86
+ nrd=0.0009062499999999999 nrs=0.0009062499999999999 sa=0 sb=0 sd=0 mult=1
XRLOAD0 OUTN AVDD AVSS sky130_fd_pr__res_xhigh_po_1p41 L=24.4 mult=1
XMIN0 OUTN VINP net1 AVSS sky130_fd_pr__nfet_05v0_nvt L=4 W=1280 nf=128 ad=185.6 as=188.5 pd=1317.12 ps=1337.7
+ nrd=0.00022656249999999998 nrs=0.00022656249999999998 sa=0 sb=0 sd=0 mult=1
XRDEG0 net2 net1 AVSS sky130_fd_pr__res_high_po_2p85 L=45.55 mult=1
xreturn0 VINP VCM AVSS tbci_bias_chain
XRLOAD1 OUTP AVDD AVSS sky130_fd_pr__res_xhigh_po_1p41 L=24.4 mult=1
XMIN1 OUTP VINN net3 AVSS sky130_fd_pr__nfet_05v0_nvt L=4 W=1280 nf=128 ad=185.6 as=188.5 pd=1317.12 ps=1337.7
+ nrd=0.00022656249999999998 nrs=0.00022656249999999998 sa=0 sb=0 sd=0 mult=1
XRDEG1 net2 net3 AVSS sky130_fd_pr__res_high_po_2p85 L=45.55 mult=1
xreturn1 VINN VCM AVSS tbci_bias_chain
.ends

* expanding   symbol:  tbci_bias_chain.sym # of pins=3
** sym_path: /foss/designs/afe/xschem/tbci_bias_chain.sym
** sch_path: /foss/designs/afe/xschem/tbci_bias_chain.sch
.subckt tbci_bias_chain SIG VCM AVSS
*.PININFO SIG:B VCM:B AVSS:B
xs0 SIG net1 AVSS tbci_bias_return
xs1 net1 net2 AVSS tbci_bias_return
xs2 net2 net3 AVSS tbci_bias_return
xs3 net3 MID AVSS tbci_bias_return
xs4 MID net4 AVSS tbci_bias_return
xs5 net4 net5 AVSS tbci_bias_return
xs6 net5 net6 AVSS tbci_bias_return
xs7 net6 VCM AVSS tbci_bias_return
.ends

* expanding   symbol:  tbci_bias_return.sym # of pins=3
** sym_path: /foss/designs/afe/xschem/tbci_bias_return.sym
** sch_path: /foss/designs/afe/xschem/tbci_bias_return.sch
.subckt tbci_bias_return SIG VCM AVSS
*.PININFO SIG:B VCM:B AVSS:B
XR0 net1 SIG AVSS sky130_fd_pr__res_xhigh_po_0p35 L=860 mult=1
XR1 net2 net1 AVSS sky130_fd_pr__res_xhigh_po_0p35 L=860 mult=1
XR2 net3 net2 AVSS sky130_fd_pr__res_xhigh_po_0p35 L=860 mult=1
XR3 net4 net3 AVSS sky130_fd_pr__res_xhigh_po_0p35 L=860 mult=1
XR4 net4 net5 AVSS sky130_fd_pr__res_xhigh_po_0p35 L=860 mult=1
XR5 net5 net6 AVSS sky130_fd_pr__res_xhigh_po_0p35 L=860 mult=1
XR6 net6 net7 AVSS sky130_fd_pr__res_xhigh_po_0p35 L=860 mult=1
XR7 net7 net8 AVSS sky130_fd_pr__res_xhigh_po_0p35 L=860 mult=1
XR8 net9 net8 AVSS sky130_fd_pr__res_xhigh_po_0p35 L=860 mult=1
XR9 net10 net9 AVSS sky130_fd_pr__res_xhigh_po_0p35 L=860 mult=1
XR10 net11 net10 AVSS sky130_fd_pr__res_xhigh_po_0p35 L=860 mult=1
XR11 net12 net11 AVSS sky130_fd_pr__res_xhigh_po_0p35 L=860 mult=1
XR12 net12 net13 AVSS sky130_fd_pr__res_xhigh_po_0p35 L=860 mult=1
XR13 net13 net14 AVSS sky130_fd_pr__res_xhigh_po_0p35 L=860 mult=1
XR14 net14 net15 AVSS sky130_fd_pr__res_xhigh_po_0p35 L=860 mult=1
XR15 net15 VCM AVSS sky130_fd_pr__res_xhigh_po_0p35 L=860 mult=1
.ends
